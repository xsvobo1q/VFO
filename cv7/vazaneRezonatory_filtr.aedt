# Ansys Electronics Desktop project, version 2021.2
materials:
  copper: permeability=0.999991 conductivity=58000000
  FR4_epoxy: permittivity=4.4 dielectric_loss_tangent=0.02

design Circuit1 (Circuit)
options: SParamCircuitDef IntegrationMethod=FFT
variables:
  wr = 1.5mm
  l1 = 5.04mm
  L = 24.5mm
  sp = 0.92mm
  cp = 1.05pF
components:
  A1 = MS_TRL(P=L-l1 W=wr)
  A2 = MS_TRL(W=wr P=l1)
  A3 = MS_VIAHOLE()
  A4 = MS_VIAHOLE()
  A5 = MS_VIAHOLE()
  C6 = CAP_()
  A7 = MS_MCPL02(W=wr P=L-l1 SP=sp)
  A8 = MS_MCPL02(W=wr P=l1 SP=sp)
  A6 = MS_VIAHOLE()
  A9 = MS_VIAHOLE()
  A10 = MS_VIAHOLE()
  A11 = MS_VIAHOLE()
  A12 = MS_VIAHOLE()
  A13 = MS_VIAHOLE()
  C1 = CAP_()
  C2 = CAP_()
  A24 = MS_MCPL03(W=wr P=L-l1 SP=sp)
  A25 = MS_MCPL03(W=wr P=l1 SP=sp)
  A14 = MS_VIAHOLE()
  A15 = MS_VIAHOLE()
  A16 = MS_VIAHOLE()
  A17 = MS_VIAHOLE()
  A18 = MS_VIAHOLE()
  A19 = MS_VIAHOLE()
  C3 = CAP_()
  C4 = CAP_(C=cp)
  C5 = CAP_()
  A20 = MS_VIAHOLE()
  A21 = MS_VIAHOLE()
  A22 = MS_VIAHOLE()
  port Port1 rz=50ohm iz=0ohm EnableNoise=false noisetemp=16.85cel
  port Port2 rz=200ohm iz=0ohm EnableNoise=false noisetemp=16.85cel
  port Port3 rz=200ohm iz=0ohm EnableNoise=false noisetemp=16.85cel
  port Port4 rz=50ohm iz=0ohm EnableNoise=false noisetemp=16.85cel
  port Port5 rz=50ohm iz=0ohm EnableNoise=false noisetemp=16.85cel
nets:
  net_1: C6.1, A5.0
  net_12: A25.0, A14.0, A15.0
  net_13: A25.1, A17.0, A16.0
  net_14: A25.2, A18.0, A19.0
  net_15: A20.0, C3.1
  net_16: A21.0, C4.1
  net_17: C5.1, A22.0
  net_18: A24.3, C3.0
  net_19: A24.4, C4.0
  net_2: A1.1, C6.0
  net_20: A24.5, C5.0
  net_22: A25.4, A24.1
  net_3: A9.0, A6.0, A8.0
  net_4: A2.0, A3.0, A4.0
  net_5: A8.1, A11.0, A10.0
  net_6: C2.1, A12.0
  net_7: C1.1, A13.0
  net_8: C2.0, A7.2
  net_9: C1.0, A7.3
  Port1: A2.1, A1.0
  Port2: A8.2, A7.0
  Port3: A8.3, A7.1
  Port4: A25.3, A24.0
  Port5: A25.5, A24.2
setups:
  LinearFrequency: LinearFrequencyData(false, 0.1, false, "", false) SweepDefinition{Variable=Freq Data="LIN 0.5GHz 2.5GHz 0.25MHz"}
reports:
  S Parameter Plot 1: dB(S(Port4,Port4)) vs Freq on LinearFrequency : LinearFrequency
  S Parameter Plot 2: dB(S(Port5,Port4)) vs Freq on LinearFrequency : LinearFrequency
