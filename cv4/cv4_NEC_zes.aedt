# Ansys Electronics Desktop project, version 2021.2
materials:
  copper: permeability=0.999991 conductivity=58000000
  FR4_epoxy: permittivity=4.4 dielectric_loss_tangent=0.02

design Circuit1 (Circuit)
options: SParamCircuitDef IntegrationMethod=FFT
variables:
  c1 = 9.2e-12farad
  l1 = 24nH
  l2 = 1.4nH  # tune 0nH..5nH
components:
  S13 = ne68133i1()
  L14 = IND_(L=l2)
  L17 = IND_(L=6.66nH)
  C18 = CAP_(C=21.08pF)
  L21 = IND_(L=12.89nH)
  C22 = CAP_(C=1.49pF)
  port Port1 rz=50ohm iz=0ohm EnableNoise=false noisetemp=16.85cel
  port Port2 rz=50ohm iz=0ohm EnableNoise=false noisetemp=16.85cel
nets:
  0: L17.1, L21.1, L14.0
  net_3: S13.ref, L14.1
  net_4: C18.1, S13.0
  Port1: L17.0, C18.0
  Port2: C22.1
  Port3: C22.0, S13.1, L21.0
setups:
  LinearFrequency: LinearFrequencyData(false, 0.1, true, "", false) SweepDefinition{Variable=Freq Data="LINC 0GHz 1.5GHz 501"}
reports:
  S Parameter Plot 1: dB(S(Port1,Port1)), dB(S(Port2,Port1)), dB(S(Port2,Port2)), dB(S(Port1,Port2)), dB(GMAX), dB(FMIN), dB(NF) vs Freq on LinearFrequency : LinearFrequency; markers MX1 at x=9.0156018e+08
  Stability Plot 1: B1, K vs Freq on LinearFrequency : LinearFrequency; markers MX1 at x=9.0110294e+08
  S Parameter Chart 1: S(Port1,Port1), S(Port2,Port2) on LinearFrequency : LinearFrequency [Freq=all]
  S-Parameters: S(Port1,Port1) on LinearFrequency : LinearFrequency [Freq=all]
  S-Parameters1: S(Port1,Port1) on LinearFrequency : LinearFrequency [Freq=all]; KCS, KCL on LinearFrequency : LinearFrequency [Freq=0.9GHz]
  S-Parameters2: S(Port1,Port1) on LinearFrequency : LinearFrequency [Freq=all]; KCS, KCL, GACS(gain=12.25dB), NC(value=1.5dB), RHOL(gamma=-0.433+j0.178 gain=12.25dB), GACL(gain=12.25dB), GACS(gain=12.25dB), RHOL(gamma=-0.403+j0.316 gain=12.25dB), GACL(gain=12.25dB), GACS(gain=12.25dB) on LinearFrequency : LinearFrequency [Freq=0.9GHz]
