# Ansys Electronics Desktop project, version 2021.2
materials:
  copper: permeability=0.999991 conductivity=58000000
  FR4_epoxy: permittivity=4.4 dielectric_loss_tangent=0.02

design Circuit1 (Circuit)
options: SParamCircuitDef IntegrationMethod=FFT
variables:
  c1 = 9.2e-12farad
  l1 = 24nH
components:
  S1 = 08CS240()
  C2 = CAP_(C=c1)
  C3 = CAP_(C=c1)
  C1 = CAP_(C=c1)
  C4 = CAP_(C=c1)
  L11 = IND_(L=l1)
  port Port1 rz=50ohm iz=0ohm EnableNoise=false noisetemp=16.85cel
  port Port2 rz=50ohm iz=0ohm EnableNoise=false noisetemp=16.85cel
  port Port3 rz=50ohm iz=0ohm EnableNoise=false noisetemp=16.85cel
  port Port4 rz=50ohm iz=0ohm EnableNoise=false noisetemp=16.85cel
nets:
  0: C3.0, C2.0, C1.0, C4.0
  Port1: C2.1, S1.Port1
  Port2: C3.1, S1.Port2
  Port3: L11.0, C1.1
  Port4: L11.1, C4.1
setups:
  LinearFrequency: LinearFrequencyData(false, 0.1, false, "", false) SweepDefinition{Variable=Freq Data="LINC 0GHz 5GHz 201"}
reports:
  S Parameter Plot 1: dB(S(Port1,Port1)), dB(S(Port2,Port1)), dB(S(Port3,Port3)), dB(S(Port4,Port3)) vs Freq on LinearFrequency : LinearFrequency
