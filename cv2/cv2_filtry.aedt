# Ansys Electronics Desktop project, version 2021.2
materials:
  copper: permeability=0.999991 conductivity=58000000
  FR4_epoxy: permittivity=4.4 dielectric_loss_tangent=0.02

design Circuit1 (Circuit)
options: SParamCircuitDef IntegrationMethod=FFT
variables:
  c1 = 1/(2*pi*fc*Rin)
  l1 = 2*Rin/(2*pi*fc)
  fc = 100000000Hz
  Rin = 50ohm
  c3 = 1.0316/(2*pi*fc2*Rin) farad
  c4 = (c3) farad
  l2 = 1.1474*Rin/(2*pi*fc2) H
  fc2 = fc*koef
  koef = 1/1.4
  l3 = 1.0173*Rin/(2*pi*fc3) H
  c5 = 0.9471/(2*pi*fc3*Rin) farad
  c6 = 0.1205/(2*pi*fc3*Rin)
  c7 = (c5) farad
  fc3 = fc*koef2
  koef2 = 1/1.34
components:
  A1 = CAP_Q(c=c1)
  A2 = CAP_Q(c=c1)
  A3 = IND_Q(L=l1)
  A4 = CAP_Q(c=c3)
  A5 = CAP_Q(c=c4)
  A6 = IND_Q(L=l2)
  A7 = CAP_Q(c=c5)
  A8 = CAP_Q(c=c7)
  A9 = IND_Q(L=l3)
  A18 = CAP_Q(c=c6)
  port Port1 rz=Rin iz=0ohm EnableNoise=false noisetemp=16.85cel
  port Port2 rz=Rin iz=0ohm EnableNoise=false noisetemp=16.85cel
  port Port3 rz=Rin iz=0ohm EnableNoise=false noisetemp=16.85cel
  port Port4 rz=Rin iz=0ohm EnableNoise=false noisetemp=16.85cel
  port Port5 rz=Rin iz=0ohm EnableNoise=false noisetemp=16.85cel
  port Port6 rz=Rin iz=0ohm EnableNoise=false noisetemp=16.85cel
nets:
  0: A1.0, A2.0, A8.0, A5.0, A7.0, A4.0
  Port1: A1.1, A3.0
  Port2: A2.1, A3.1
  Port3: A6.0, A4.1
  Port4: A6.1, A5.1
  Port5: A18.0, A7.1, A9.0
  Port6: A18.1, A8.1, A9.1
setups:
  LinearFrequency: LinearFrequencyData(false, 0.1, false, "", false) SweepDefinition{Variable=Freq Data="DEC 10MHz 1GHz 200"}
reports:
  S Parameter Plot 1: dB(S(Port1,Port1)), dB(S(Port2,Port1)), dB(S(Port3,Port3)), dB(S(Port4,Port3)), dB(S(Port5,Port5)), dB(S(Port6,Port5)) vs Freq on LinearFrequency : LinearFrequency; markers MX1 at x=1e+08
