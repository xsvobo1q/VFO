# Ansys Electronics Desktop project, version 2021.2
materials:
  copper: permeability=0.999991 conductivity=58000000
  FR4_epoxy: permittivity=4.4 dielectric_loss_tangent=0.02

design Circuit1 (Circuit)
options: SParamCircuitDef IntegrationMethod=FFT
variables:
  L1 = 1.5nH  # tune 0.1nH..5nH
  Rp = 150ohm  # tune 50ohm..500ohm
  Rs = 18ohm  # tune 1ohm..200ohm
  l2 = 22mm  # tune 10mm..30mm
components:
  S2 = BFP720ESD_w_noise_VCE_4()
  L3 = IND_(L=L1)
  R4 = RES_(R=Rs)
  R5 = RES_(R=Rp)
  C17 = CAP_(C=1pF)
  A24 = MS_TRL(W=1.43mm P=l2)
  A1 = MS_TRL(W=0.4mm P=18mm)
  C1 = CAP_(C=100nF)
  A2 = MS_TRL(W=0.4mm P=18mm)
  C2 = CAP_(C=100nF)
  port Port1 rz=50ohm iz=0ohm EnableNoise=false noisetemp=16.85cel
  port Port2 rz=50ohm iz=0ohm EnableNoise=false noisetemp=16.85cel
nets:
  0: L3.0, C17.1, C1.0, R5.0, C2.0
  net_1: L3.1, S2.ref
  net_2: S2.1, R4.0, R5.1, A2.0
  net_3: A24.1, S2.0, A1.0
  net_4: C1.1, A1.1
  net_5: C2.1, A2.1
  Port1: A24.0, C17.0
  Port2: R4.1
setups:
  LinearFrequency: LinearFrequencyData(false, 0.1, true, "", false) SweepDefinition{Variable=Freq Data="LIN 0.05GHz 3.5GHz 0.05GHz"}
reports:
  S Parameter Plot 1: dB(S(Port1,Port1)), dB(S(Port2,Port1)), dB(S(Port1,Port2)), dB(S(Port2,Port2)), dB(MSG), dB(GMAX), dB(FMIN), dB(NF) vs Freq on LinearFrequency : LinearFrequency; markers MX1 at x=2.4042272e+09
  Stability Plot 1: B1, K, dB(FMIN), dB(NF) vs Freq on LinearFrequency : LinearFrequency; markers MX1 at x=34906915, MY1 at y=2.82119
  S Parameter Chart 1: S(Port1,Port1), S(Port2,Port2) on LinearFrequency : LinearFrequency [Freq=all]
  S-Parameters: S(Port1,Port1) on LinearFrequency : LinearFrequency [Freq=all]; KCS, KCL on LinearFrequency : LinearFrequency [Freq=2.4GHz]
  S-Parameters1: S(Port1,Port1) on LinearFrequency : LinearFrequency [Freq=all]; NC(value=0.86dB), KCS, KCL on LinearFrequency : LinearFrequency [Freq=2.4GHz]
  S-Parameters2: S(Port1,Port1) on LinearFrequency : LinearFrequency [Freq=all]; NC(value=0.93dB) on LinearFrequency : LinearFrequency [Freq=2.4GHz]
