# Ansys Electronics Desktop project, version 2021.2
materials:
  copper: permeability=0.999991 conductivity=58000000
  FR4_epoxy: permittivity=4.4 dielectric_loss_tangent=0.02

design Circuit1 (Circuit)
options: SParamCircuitDef IntegrationMethod=FFT
variables:
  c1 = 33pF
  c2 = 2.88pF
  c3 = 53.8pF
  c4 = 7.8pF
  c5 = 28.8pF
  l1 = 96.6nH
  l2 = 82nH
  l1id = 96.56nH
  l2id = 82.63nH
  c1id = 32.53pF
  c2id = 2.79pF
  c3id = 53.12pF
  c4id = 7.73pF
  c5id = 28.4pF
  c1re = 33pF  # tune 16.5pF..49.5pF
  c2re = 2.88pF  # tune 1.44pF..4.32pF
  c3re = 53.8pF  # tune 26.9pF..80.7pF
  c4re = 7.8pF  # tune 3.9pF..11.7pF
  c5re = 28.8pF  # tune 14.4pF..43.2pF
components:
  C1 = CAP_(C=c1)
  C2 = CAP_(C=c2)
  C3 = CAP_(C=c3)
  C4 = CAP_(C=c4)
  C5 = CAP_(C=c5)
  L6 = IND_(L=l1)
  L7 = IND_(L=l2)
  C6 = CAP_(C=c1re)
  C7 = CAP_(C=c2re)
  C8 = CAP_(C=c3re)
  C9 = CAP_(C=c4re)
  C10 = CAP_(C=c5re)
  S23 = 08CS820()
  S24 = 08CS101()
  C11 = CAP_(C=c1id)
  C12 = CAP_(C=c2id)
  C13 = CAP_(C=c3id)
  C14 = CAP_(C=c4id)
  C15 = CAP_(C=c5id)
  L40 = IND_(L=l2id)
  L41 = IND_(L=l1id)
  port Port1 rz=50ohm iz=0ohm EnableNoise=false noisetemp=16.85cel
  port Port2 rz=50ohm iz=0ohm EnableNoise=false noisetemp=16.85cel
  port Port3 rz=50ohm iz=0ohm EnableNoise=false noisetemp=16.85cel
  port Port4 rz=50ohm iz=0ohm EnableNoise=false noisetemp=16.85cel
  port Port5 rz=50ohm iz=0ohm EnableNoise=false noisetemp=16.85cel
  port Port6 rz=50ohm iz=0ohm EnableNoise=false noisetemp=16.85cel
nets:
  0: C3.0, C5.0, C6.0, C8.0, C1.0, C13.0, C10.0, C11.0, C15.0
  net_1: C7.1, C8.1, C9.0, S23.0, S24.1
  net_2: C2.1, C3.1, L6.1, C4.0, L7.0
  net_3: C13.1, L41.1, C14.0, C12.1, L40.0
  Port1: C2.0, L6.0, C1.1
  Port2: C4.1, C5.1, L7.1
  Port3: C6.1, C7.0, S24.0
  Port4: C9.1, S23.1, C10.1
  Port5: C11.1, L41.0, C12.0
  Port6: C14.1, C15.1, L40.1
setups:
  LinearFrequency: LinearFrequencyData(false, 0.1, false, "", false) SweepDefinition{Variable=Freq Data="DEC 100kHz 10GHz 501"}
reports:
  S Parameter Plot 1: dB(S(Port2,Port1)) vs Freq on LinearFrequency : LinearFrequency; markers MX1 at x=1.1210309e+08
  S Parameter Plot 2: dB(S(Port6,Port5)) vs Freq on LinearFrequency : LinearFrequency
  S Parameter Plot 3: dB(S(Port4,Port3)) vs Freq on LinearFrequency : LinearFrequency; markers MX1 at x=27725655
