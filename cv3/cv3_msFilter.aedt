# Ansys Electronics Desktop project, version 2021.2
materials:
  copper: permeability=0.999991 conductivity=58000000
  FR4_epoxy: permittivity=4.4 dielectric_loss_tangent=0.02

design Circuit1 (Circuit)
options: SParamCircuitDef IntegrationMethod=FFT
variables:
  w0 = 1.44mm
  wl = 0.4mm
  ll = 22mm  # tune 6.75mm..25mm
  wc = 8.8mm  # tune 2mm..14mm
  lc = 8.5mm  # tune 5.5mm..25mm
  ll2 = 21.5mm  # tune 8.1mm..25mm
  wc2 = 9.2mm  # tune 2mm..15mm
  lc2 = 9.5mm  # tune 5.25mm..25mm
components:
  A1 = MS_TRL(W=w0)
  A2 = MS_TRL(W=wl P=ll)
  A3 = MS_TRL(W=wc P=lc)
  A4 = MS_TRL(W=wl P=ll)
  A5 = MS_TRL(W=w0)
  A6 = MS_TRL(W=w0)
  A7 = MS_TRL(W=wl P=ll)
  A8 = MS_TRL(W=wc P=lc)
  A9 = MS_TRL(W=wl P=ll)
  A10 = MS_TRL(W=w0)
  A21 = MS_STEP(W1=w0 W2=wl)
  A11 = MS_STEP(W1=wl W2=wc)
  A12 = MS_STEP(W1=wl W2=wc)
  A13 = MS_STEP(W1=w0 W2=wl)
  A14 = MS_TRL(W=w0)
  A15 = MS_TRL(W=wl P=ll2)
  A17 = MS_TRL(W=wl P=ll2)
  A18 = MS_TRL(W=w0)
  A19 = MS_STEP(W1=w0 W2=wl)
  A23 = MS_STEP(W1=w0 W2=wl)
  A50 = MS_TEEC(W1=wl W2=wl W3=wc2)
  W51 = MS_OPEN_STUB(W=wc2 P=lc2)
  port Port1 rz=50ohm iz=0ohm EnableNoise=false noisetemp=16.85cel
  port Port2 rz=50ohm iz=0ohm EnableNoise=false noisetemp=16.85cel
  port Port3 rz=50ohm iz=0ohm EnableNoise=false noisetemp=16.85cel
  port Port4 rz=50ohm iz=0ohm EnableNoise=false noisetemp=16.85cel
  port Port5 rz=50ohm iz=0ohm EnableNoise=false noisetemp=16.85cel
  port Port6 rz=50ohm iz=0ohm EnableNoise=false noisetemp=16.85cel
nets:
  net_1: A2.0, A1.1
  net_11: A7.1, A11.0
  net_12: A8.0, A11.1
  net_13: A8.1, A12.1
  net_14: A9.0, A12.0
  net_15: A9.1, A13.1
  net_16: A10.0, A13.0
  net_17: A50.1, A17.0
  net_19: A17.1, A23.1
  net_2: A2.1, A3.0
  net_20: A18.0, A23.0
  net_21: A50.2, W51.0
  net_22: A15.0, A19.1
  net_24: A50.0, A15.1
  net_3: A3.1, A4.0
  net_4: A5.0, A4.1
  net_5: A21.0, A6.1
  net_6: A19.0, A14.1
  net_9: A21.1, A7.0
  Port1: A1.0
  Port2: A5.1
  Port3: A6.0
  Port4: A10.1
  Port5: A14.0
  Port6: A18.1
setups:
  LinearFrequency: LinearFrequencyData(false, 0.1, false, "", false) SweepDefinition{Variable=Freq Data="LINC 0GHz 5GHz 201"}
reports:
  S Parameter Plot 1: dB(S(Port1,Port1)), dB(S(Port2,Port1)), dB(S(Port3,Port3)), dB(S(Port4,Port3)), dB(S(Port5,Port5)), dB(S(Port6,Port5)) vs Freq on LinearFrequency : LinearFrequency; markers MX1 at x=1.0022272e+09

design Circuit2 (Circuit)
options: SParamCircuitDef IntegrationMethod=FFT
variables:
  w0 = 1.44mm
  wl = 0.4mm
  ll1 = 11.3mm
  ll2 = 4.355mm
  wc2 = 7mm  # tune 2mm..12mm
  lc2 = 7.4mm  # tune 9.3mm..27.9mm
  ll3 = 19.9mm
  ll4 = 8mm
  wc4 = 7mm  # tune 2mm..12mm
  ll5 = 18.2mm
  wc6 = 4mm
  lc6 = 13.9mm
  lc4 = 7mm  # tune 6.2mm..18.6mm
components:
  A53 = MS_TRL(W=w0)
  A54 = MS_STEP(W1=w0 W2=wl)
  A55 = MS_TRL(W=wl P=ll1)
  A56 = MS_TRL(W=wl P=ll3)
  A57 = MS_TRL(W=wl P=ll5)
  A58 = MS_STEP(W1=wl W2=wc6)
  A59 = MS_TRL(W=wc6 P=lc6)
  A60 = MS_STEP(W1=wc6 W2=w0)
  A61 = MS_TRL(W=w0)
  A62 = MS_TEEC(W1=wl W2=wl W3=wl)
  A63 = MS_TEEC(W1=wl W2=wl W3=wl)
  A65 = MS_STEP(W2=wl W1=wc4)
  A66 = MS_STEP(W2=wl W1=wc2)
  A67 = MS_TRL(W=wl P=ll4)
  A68 = MS_TRL(W=wl P=ll2)
  W69 = MS_OPEN_STUB(W=wc4 P=lc4)
  W70 = MS_OPEN_STUB(W=wc2 P=lc2)
  port Port1 rz=50ohm iz=0ohm EnableNoise=false noisetemp=16.85cel
  port Port2 rz=50ohm iz=0ohm EnableNoise=false noisetemp=16.85cel
nets:
  net_1: A54.0, A53.1
  net_10: W69.0, A65.0
  net_11: A66.0, W70.0
  net_12: A66.1, A68.0
  net_13: A67.0, A65.1
  net_14: A63.0, A55.1
  net_15: A63.1, A56.0
  net_16: A62.1, A57.0
  net_2: A54.1, A55.0
  net_3: A58.0, A57.1
  net_4: A58.1, A59.0
  net_5: A60.0, A59.1
  net_6: A60.1, A61.0
  net_7: A62.0, A56.1
  net_8: A62.2, A67.1
  net_9: A68.1, A63.2
  Port1: A53.0
  Port2: A61.1
setups:
  LinearFrequency: LinearFrequencyData(false, 0.1, false, "", false) SweepDefinition{Variable=Freq Data="LINC 0GHz 3GHz 501"}
optimetrics:
  ParametricSetup1: Parametric UseFastCalculationUpdateAlgo disabled SaveSolutions Sim._Setups=[LinearFrequency]
    sweep wc2: LIN 2mm 12mm 1mm
    sweep lc2: LIN 5mm 15mm 1mm
reports:
  S Parameter Plot 1: dB(S(Port1,Port1)), dB(S(Port2,Port1)) vs Freq on LinearFrequency : LinearFrequency; markers MX1 at x=1.6414254e+09, MX2 at x=1.2783964e+09, MX3 at x=1.0022272e+09
  S Parameter Plot 1_1: dB(S(Port1,Port1)) vs Freq on LinearFrequency : LinearFrequency; dB(S(Port2,Port1)) vs Freq on LinearFrequency : LinearFrequency [wc2=all lc2=all]; markers MX1 at x=1.6414254e+09, MX2 at x=1.2783964e+09, MX3 at x=1.0022272e+09
