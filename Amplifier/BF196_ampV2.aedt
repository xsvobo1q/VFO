# Ansys Electronics Desktop project, version 2021.2
materials:
  copper: permeability=0.999991 conductivity=58000000
  FR4_epoxy: permittivity=4.4 dielectric_loss_tangent=0.02

design Circuit1 (Circuit)
options: SParamCircuitDef IntegrationMethod=FFT
variables:
  Rb2 = 6.8kOhm
  Rc1 = 100ohm
  Rb1 = 10kOhm
  Rc2 = 47ohm
  R1 = 330ohm
  C2 = 14.9pF
  C3 = 4.7pF
  C1 = 13.5pF
  L1 = 2.7nH
  L2 = 6nH
  C2_r = 15pF
  C1_r = 10.5pF
  C11_r = 6.8pF
components:
  S1 = BFP196W_w_noise_VCE_3()
  R1 = RES_(R=Rb2)
  R2 = RES_(R=Rc1)
  R8 = RES_(R=Rb1)
  R9 = RES_(R=Rc2)
  R10 = RES_(R=R1)
  C1 = CAP_(C=1e-08)
  C2 = CAP_(C=1e-09)
  C3 = CAP_(C=C2_r)
  C4 = CAP_(C=C3)
  C5 = CAP_(C=C1_r)
  S43 = 08CS020()
  S50 = 08CS060()
  C6 = CAP_(C=C11_r)
  port Port3 rz=50ohm iz=0ohm EnableNoise=false noisetemp=16.85cel
  port Port4 rz=50ohm iz=0ohm EnableNoise=false noisetemp=16.85cel
nets:
  0: S1.ref, R10.0, C2.0, C1.1, R9.1, R1.1, S43.0, S50.0
  net_10: R10.1, C3.1, C4.0, S50.1
  net_11: C5.1, S43.1, C6.0
  net_6: R8.1, C2.1, R1.0
  net_7: C1.0, R9.0, R2.1
  net_8: C5.0, S1.Port1, R8.0
  net_9: S1.Port2, R2.0, C3.0
  Port3: C6.1
  Port4: C4.1
setups:
  LinearFrequency: LinearFrequencyData(false, 0.1, true, "", false) SweepDefinition{Variable=Freq Data="LINC 100MHz 1.5GHz 301"}
reports:
  S Parameter Plot 1: dB(S(Port3,Port3)), dB(S(Port4,Port3)), dB(S(Port4,Port4)) vs Freq on LinearFrequency : LinearFrequency; markers MX1 at x=9.0116656e+08
  Stability Plot 1: B1, K vs Freq on LinearFrequency : LinearFrequency
  Gain Plot 1: dB(MSG), dB(NF), dB(GMAX) vs Freq on LinearFrequency : LinearFrequency; markers MX1 at x=9.0135397e+08
