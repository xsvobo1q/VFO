# Ansys Electronics Desktop project, version 2021.2
materials:
  copper: permeability=0.999991 conductivity=58000000
  FR4_epoxy: permittivity=4.4 dielectric_loss_tangent=0.02

design Circuit2 (Circuit)
options: SParamCircuitDef IntegrationMethod=FFT
variables:
  Rb1 = 10kOhm
  Rb2 = 6.8kOhm
  Rc1 = 100ohm
  Rc2 = 47ohm
  C1 = 13.5pF
  C3 = 4.7pF
  C2 = 14.9pF
  L1 = 2.7nH
  R1 = 330ohm
  L2 = 6nH
  C1_r = 10.5pF
  C2_r = 15pF
  C11_r = 6.8pF
components:
  S2 = BFP196W_w_noise_VCE_3()
  R3 = RES_(R=Rb2)
  R4 = RES_(R=Rc1)
  R5 = RES_(R=Rb1)
  R6 = RES_(R=Rc2)
  R7 = RES_(R=R1)
  C8 = CAP_(C=1e-08)
  C9 = CAP_(C=1e-09)
  C10 = CAP_(C=C2)
  C11 = CAP_(C=C3)
  C12 = CAP_(C=C1)
  L13 = IND_(L=L1)
  L14 = IND_(L=L2)
  S1 = BFP196W_w_noise_VCE_3()
  R1 = RES_(R=Rb2)
  R2 = RES_(R=Rc1)
  R8 = RES_(R=Rb1)
  R9 = RES_(R=Rc2)
  R10 = RES_(R=R1)
  C1 = CAP_(C=1e-08)
  C2 = CAP_(C=1e-09)
  C3 = CAP_(C=C2_r)
  C4 = CAP_(C=C3)
  C5 = CAP_(C=C1_r)
  S43 = 08CS020()
  S50 = 08CS060()
  C6 = CAP_(C=C11_r)
  port Port1 rz=50ohm iz=0ohm EnableNoise=false noisetemp=16.85cel
  port Port2 rz=50ohm iz=0ohm EnableNoise=false noisetemp=16.85cel
  port Port3 rz=50ohm iz=0ohm EnableNoise=false noisetemp=16.85cel
  port Port4 rz=50ohm iz=0ohm EnableNoise=false noisetemp=16.85cel
nets:
  0: R3.1, R6.1, S2.ref, R7.0, C9.0, C8.1, C2.0, C1.1, L14.0, R9.1, L13.0, S1.ref, R1.1, R10.0, S50.0, S43.0
  net_1: R3.0, R5.1, C9.1
  net_10: C3.1, C4.0, R10.1, S50.1
  net_11: C5.1, C6.0, S43.1
  net_2: R6.0, R4.1, C8.0
  net_3: S2.Port1, R5.0, C12.0
  net_4: S2.Port2, R4.0, C10.0
  net_5: R7.1, C10.1, C11.0, L14.1
  net_6: C2.1, R8.1, R1.0
  net_7: C1.0, R2.1, R9.0
  net_8: R8.0, S1.Port1, C5.0
  net_9: C3.0, R2.0, S1.Port2
  Port1: C12.1, L13.1
  Port2: C11.1
  Port3: C6.1
  Port4: C4.1
setups:
  LinearFrequency: LinearFrequencyData(false, 0.1, true, "", false) SweepDefinition{Variable=Freq Data="LINC 250MHz 1.5GHz 201"}
reports:
  S Parameter Plot 1: dB(S(Port1,Port1)), dB(S(Port2,Port1)), dB(S(Port2,Port2)), dB(S(Port1,Port2)) vs Freq on LinearFrequency : LinearFrequency; markers MX1 at x=9.0116656e+08
  S Parameter Plot 3: dB(S(Port4,Port3)), dB(S(Port4,Port4)), dB(S(Port3,Port3)) vs Freq on LinearFrequency : LinearFrequency; markers MX1 at x=9.0156965e+08
