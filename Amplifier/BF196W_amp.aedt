# Ansys Electronics Desktop project, version 2021.2
materials:
  copper: permeability=0.999991 conductivity=58000000
  FR4_epoxy: permittivity=4.4 dielectric_loss_tangent=0.02

design Circuit2 (Circuit)
options: SParamCircuitDef IntegrationMethod=FFT
variables:
  Rb1 = 10kOhm
  Rb2 = 6.8kOhm
  Rc1 = 100ohm
  Rc2 = 47ohm
  C1 = 13.5pF
  C3 = 4.7pF
  C2 = 14.9pF
  L1 = 2.7nH
  R1 = 330ohm
  L2 = 6nH
  C1_r = 10.5pF
  C2_r = 15pF
  C11_r = 6.8pF
components:
  S2 = BFP196W_w_noise_VCE_3()
  R3 = RES_(R=Rb2)
  R4 = RES_(R=Rc1)
  R5 = RES_(R=Rb1)
  R6 = RES_(R=Rc2)
  C8 = CAP_(C=1e-08)
  C9 = CAP_(C=1e-09)
  C10 = CAP_(C=C2)
  C11 = CAP_(C=C3)
  C12 = CAP_(C=C1)
  L13 = IND_(L=L1)
  L14 = IND_(L=L2)
  port Port1 rz=50ohm iz=0ohm EnableNoise=false noisetemp=16.85cel
  port Port2 rz=50ohm iz=0ohm EnableNoise=false noisetemp=16.85cel
nets:
  0: R6.1, R3.1, L13.0, C9.0, S2.ref, C8.1, L14.0
  net_1: R3.0, C9.1, R5.1
  net_2: R4.1, R6.0, C8.0
  net_3: R5.0, S2.Port1, C12.0
  net_4: R4.0, S2.Port2, C10.0
  net_5: C11.0, C10.1, L14.1
  Port1: L13.1, C12.1
  Port2: C11.1
setups:
  LinearFrequency: LinearFrequencyData(false, 0.1, true, "", false) SweepDefinition{Variable=Freq Data="LINC 100MHz 1.5GHz 301"}
reports:
  Stability Plot 1: B1, K vs Freq on LinearFrequency : LinearFrequency
  S Parameter Plot 1: dB(S(Port1,Port1)), dB(S(Port2,Port1)), dB(S(Port1,Port2)), dB(S(Port2,Port2)) vs Freq on LinearFrequency : LinearFrequency; markers MX1 at x=9.0156965e+08
  Gain Plot 1: dB(MSG), dB(GMAX), dB(NF) vs Freq on LinearFrequency : LinearFrequency
