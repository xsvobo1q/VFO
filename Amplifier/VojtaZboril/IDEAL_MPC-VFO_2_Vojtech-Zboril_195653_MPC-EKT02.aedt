# Ansys Electronics Desktop project, version 2019.3
materials:
  copper: permeability=0.999991 conductivity=58000000
  FR4_epoxy: permittivity=4.4 dielectric_loss_tangent=0.02

design Circuit1 (Circuit)
options: SParamCircuitDef IntegrationMethod=FFT
variables:
  R1 = 330ohm  # tune 100ohm..700ohm
  C1_pp = 16.2pF  # tune 1pF..40pF
  C2 = 28pF  # tune 1pF..40pF
  C3 = 4.2pF  # tune 1pF..40pF
  L1 = 2.9nH  # tune 1nH..40nH
  L2 = 7.3nH  # tune 1nH..40nH
components:
  R1 = RES_(R=R1)
  R2 = RES_(R=190)
  R3 = RES_(R=10)
  R4 = RES_(R=12200)
  R5 = RES_(R=5800)
  C6 = CAP_(C=C1_pp)
  C7 = CAP_(C=C2)
  C8 = CAP_(C=C3)
  C9 = CAP_(C=1e-08)
  C10 = CAP_(C=1e-09)
  S11 = BFP196W_w_noise_VCE_3()
  L13 = IND_(L=L2)
  L14 = IND_(L=L1)
  port Port1 pnum=1 rz=50ohm iz=0ohm EnableNoise=false noisetemp=16.85cel
  port Port2 pnum=2 rz=50ohm iz=0ohm EnableNoise=false noisetemp=16.85cel
nets:
  0: S11.ref, L13.0, C9.1, L14.0, R3.1, R5.1, R1.0, C10.0
  net_2: R4.0, S11.0, C6.1
  net_3: R4.1, R5.0, C10.1
  net_4: C7.0, S11.1, R2.0
  net_5: C7.1, L13.1, R1.1, C8.0
  net_6: C9.0, R3.0, R2.1
  Port1: C6.0, L14.1
  Port2: C8.1
setups:
  LinearFrequency: LinearFrequencyData(false, 0.1, true, "", false) SweepDefinition{Variable=F Data="DEC 0.1GHz 1.5GHz 201"}
reports:
  S Parameter Plot 1: dB(S(Port1,Port1)), dB(S(Port2,Port1)), dB(S(Port1,Port2)), dB(S(Port2,Port2)) vs F on LinearFrequency : LinearFrequency; markers MX1 at x=8e+08
  Noise Plot 1: dB(NF), dB(MSG), dB(GMAX), K, B1 vs F on LinearFrequency : LinearFrequency; markers MX1 at x=8e+08
