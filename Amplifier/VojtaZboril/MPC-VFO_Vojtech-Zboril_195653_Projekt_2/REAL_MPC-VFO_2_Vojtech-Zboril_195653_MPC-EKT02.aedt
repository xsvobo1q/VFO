# Ansys Electronics Desktop project, version 2019.3
materials:
  copper: permeability=0.999991 conductivity=58000000
  FR4_epoxy: permittivity=4.4 dielectric_loss_tangent=0.02

design Circuit1 (Circuit)
options: SParamCircuitDef IntegrationMethod=FFT
variables:
  R1 = 220ohm  # tune 100ohm..700ohm
  C1_pp = 15pF  # tune 1pF..40pF
  C2 = 33pF  # tune 1pF..40pF
  C3 = 4.7pF  # tune 1pF..40pF
  L1 = 3nH  # tune 1nH..40nH
  L2 = 7.5nH  # tune 1nH..40nH
components:
  R8 = RES_(R=R1)
  R12 = RES_(R=220)
  R11 = RES_(R=10)
  R9 = RES_(R=10000)
  R10 = RES_(R=6800)
  C1 = CAP_(C=C1_pp)
  C2 = CAP_(C=C2)
  C3 = CAP_(C=C3)
  C5 = CAP_(C=1e-08)
  C4 = CAP_(C=1e-09)
  S11 = BFP196W_w_noise_VCE_3()
  L7 = IND_(L=L2)
  L6 = IND_(L=L1)
  port Port1 pnum=1 rz=50ohm iz=0ohm EnableNoise=false noisetemp=16.85cel
  port Port2 pnum=2 rz=50ohm iz=0ohm EnableNoise=false noisetemp=16.85cel
nets:
  0: R11.1, C5.1, C4.0, R8.0, R10.1, S11.ref, L6.0, L7.0
  net_2: C1.1, R9.0, S11.0
  net_3: C4.1, R10.0, R9.1
  net_4: C2.0, R12.0, S11.1
  net_5: C2.1, C3.0, R8.1, L7.1
  net_6: R11.0, C5.0, R12.1
  Port1: C1.0, L6.1
  Port2: C3.1
setups:
  LinearFrequency: LinearFrequencyData(false, 0.1, true, "", false) SweepDefinition{Variable=F Data="DEC 0.1GHz 1.5GHz 201"}
reports:
  S Parameter Plot 1: dB(S(Port1,Port1)), dB(S(Port2,Port1)), dB(S(Port1,Port2)), dB(S(Port2,Port2)) vs F on LinearFrequency : LinearFrequency; markers MX1 at x=8e+08
  Noise Plot 1: dB(NF), dB(MSG), K, B1, dB(GMAX) vs F on LinearFrequency : LinearFrequency; markers MX1 at x=8e+08
  S Parameter Plot 2: dB(S(Port1,Port1)), dB(S(Port2,Port1)), dB(S(Port1,Port2)), dB(S(Port2,Port2)) vs F on LinearFrequency : LinearFrequency; markers MX1 at x=8e+08
  S Parameter Plot 3:
  Gain Plot 1: dB(MSG), K, B1, dB(GMAX) vs F on LinearFrequency : LinearFrequency; markers MX1 at x=8e+08
